xnb (vb vb 0 0) nmos

xn5 (3 vb 0 0) nmos
xn1 (1 vip 3 0) nmos
xn2 (2 vin 3 0) nmos
xp3 (1 1 vdd! vdd!) pmos
xp4 (2 2 vdd! vdd!) pmos
xp6 (2 1 vdd! vdd!) pmos
xp7 (1 2 vdd! vdd!) pmos

xp8 (out 2 vdd! vdd!) pmos
xp9 (4 1 vdd! vdd!) pmos
xn10 (4 4 0 0) nmos
xn11 (out 4 0 0) nmos
